Passive linear AC weighted sums - capacitor core only
* All sources are 100 kHz phasors; +/- encoding uses 0/180-degree phase.
* No transistors in the passive computation network.
Vxp1 xp1 0 AC 0.8 0
Vxm1 xm1 0 AC 0.8 180
Vxp2 xp2 0 AC 0.4 180
Vxm2 xm2 0 AC 0.4 0
Vxp3 xp3 0 AC 0.2 0
Vxm3 xm3 0 AC 0.2 180
C01 xp1 y0 50p
C02 xm2 y0 25p
C03 xp3 y0 75p
Cg0 y0 0 50p
C11 xm1 y1 30p
C12 xp2 y1 60p
C13 xp3 y1 40p
Cg1 y1 0 70p
.ac lin 1 100k 100k
.print ac vr(y0) vi(y0) vr(y1) vi(y1)
.end
